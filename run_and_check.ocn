simulator( 'spectre )
design( "/filespace/w/wchen329/cadence/simulation/reg_16bit_tb/spectre/schematic/netlist/netlist")
resultsDir( "/filespace/w/wchen329/cadence/simulation//spectre/schematic")
modelFile(
    '("/filespace/w/wchen329/ece555/cadence/modelfile18" "")
)
stimulusFile( ?xlate nil
    "/filespace/w/wchen329/ECE555_project/vectors.stim"
)
analysis('tran ?stop "18n" ?errpreset "moderate" )
envOption(
		'analysisOrder list("tran")
		'switchViewList '( "spectre cmos_sch cmos.sch extracted schematic" )
)
save( 'v "/clk" "/Q<15>" "/Q<14>" "/Q<13>" "/Q<12>" "/Q<11>" "/Q<10>" "/Q<9>" "/Q<8>" "/Q<7>" "/Q<6>" "/Q<5>" "/Q<4>" "/Q<3>" "/Q<2>" "/Q<1>" "/Q<0>" )
save( 'i "/V0/PLUS" )
temp( 27 )
createNetlist()
run()
selectResults("tran")
ocnPrint(?output "cadence/simulation/sim_out.txt" ?precision 16 ?numberNotation `scientific v("/clk") v("/Q<15>") v("/Q<14>") v("/Q<13>") v("/Q<12>") v("/Q<11>") v("/Q<10>") v("/Q<9>") v("/Q<8>") v("/Q<7>") v("/Q<6>") v("/Q<5>") v("/Q<4>") v("/Q<3>") v("/Q<2>") v("/Q<1>") v("/Q<0>") i("/V0/PLUS") ?step 0.025n)
id=ipcBeginProcess("~ejhoffman/perl_progs/check_res.pl reg_16bit_tb")
ipcWaitForChild(id)
